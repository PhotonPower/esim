Common-emitter amplifier with an RC filter subcircuit (SPICE netlist)
* Translate and run:
*   python3 tools/spice2json.py examples/spice/amplifier.cir -o amplifier.json
*   ./build/esim amplifier.json

.param rload=10k cfilt=1n

VCC vcc 0 DC 12
Vin in 0 DC 0 AC 1 SIN(0 10m 1k)

Cin in b 10u
R1 vcc b 47k
R2 b 0 10k
Q1 c b e QGEN
RC vcc c 4.7k
RE e 0 1k
CE e 0 100u
Cout c out 10u
RL out 0 {rload}

* low-pass behind the amplifier, used through a subcircuit
X1 out filt rcfilter c={cfilt}
D1 filt clamp DGEN
Vclamp clamp 0 DC 3

.subckt rcfilter a b r=1k c=10n
Rf a b {r}
Cf b 0 {c}
.ends

* general models (textbook values, no particular parts)
.model QGEN NPN(Is=1e-14 Bf=200 Br=2 Vaf=100
+ Ikf=0.3 Rb=10 Rc=1 Cje=10p Cjc=5p
+ Tf=0.5n Tr=50n)
.model DGEN D(Is=2n Rs=0.5 N=1.75 Cjo=4p M=0.4 Tt=20n)

.op
.ac dec 20 10 10meg
.noise v(out) Vin dec 10 10 100k
.tran 10u 5m
.four 1k v(out)
.print tran v(in) v(out) v(filt)
.end
