Common-emitter amplifier with an RC filter subcircuit (SPICE netlist)
* Translate and run:
*   python3 tools/spice2json.py examples/spice/amplifier.cir -o amplifier.json
*   ./build/esim amplifier.json

.param rload=10k cfilt=1n

VCC vcc 0 DC 12
Vin in 0 DC 0 AC 1 SIN(0 10m 1k)

Cin in b 10u
R1 vcc b 47k
R2 b 0 10k
Q1 c b e Q2N2222
RC vcc c 4.7k
RE e 0 1k
CE e 0 100u
Cout c out 10u
RL out 0 {rload}

* low-pass behind the amplifier, used through a subcircuit
X1 out filt rcfilter c={cfilt}
D1 filt clamp D1N4148
Vclamp clamp 0 DC 3

.subckt rcfilter a b r=1k c=10n
Rf a b {r}
Cf b 0 {c}
.ends

.model Q2N2222 NPN(Is=14.34f Xti=3 Eg=1.11 Vaf=74.03 Bf=255.9 Ne=1.307
+ Ise=14.34f Ikf=.2847 Xtb=1.5 Br=6.092 Nc=2 Isc=0 Ikr=0 Rc=1 Cjc=7.306p
+ Mjc=.3416 Vjc=.75 Fc=.5 Cje=22.01p Mje=.377 Vje=.75 Tr=46.91n Tf=411.1p Rb=10)
.model D1N4148 D(Is=2.52n Rs=.568 N=1.752 Cjo=4p M=.4 Tt=20n)

.op
.ac dec 20 10 10meg
.noise v(out) Vin dec 10 10 100k
.tran 10u 5m
.four 1k v(out)
.print tran v(in) v(out) v(filt)
.end
